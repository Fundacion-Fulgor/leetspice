.lib ${pdk_root}/ihp-sg13g2/libs.tech/ngspice/models/cornerMOSlv.lib mos_${corner}
.include submission.spice
.temp ${temperature}
VDD vdd 0 1.2
VIN in 0 PULSE(1.2 0 2n 20p 20p 4n 8n)
CLOAD out 0 10f
XDUT in out vdd 0 inverter
.control
tran 1p 12n
meas tran tplh_s TRIG v(in) VAL=0.6 FALL=1 TARG v(out) VAL=0.6 RISE=1
meas tran tphl_s TRIG v(in) VAL=0.6 RISE=1 TARG v(out) VAL=0.6 FALL=1
meas tran average_current_a AVG i(VDD) FROM=2n TO=10n
let tphl=tphl_s*1e12
let tplh=tplh_s*1e12
let average_current=abs(average_current_a)*1e6
echo tphl $$&tphl > results.data
echo tplh $$&tplh >> results.data
echo average_current $$&average_current >> results.data
quit
.endc
.end
