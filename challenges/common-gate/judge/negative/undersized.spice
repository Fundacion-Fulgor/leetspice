.subckt common_gate in out bias vdd vss
XMN out bias in vss sg13_lv_nmos W=0.3u L=0.5u ng=1 m=1
RLOAD vdd out 20k
.ends common_gate
