.subckt common_gate in out bias vdd vss
XMN out in vss vss sg13_lv_nmos W=8u L=0.26u ng=2 m=1
RLOAD vdd out 20k
.ends common_gate
