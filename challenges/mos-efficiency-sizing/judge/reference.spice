.subckt mos_efficiency d g s b
XMN d g s b sg13_lv_nmos W=1.2u L=0.26u ng=1 m=1
.ends mos_efficiency
