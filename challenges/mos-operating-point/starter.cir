.subckt mos_operating_point d g s b
XMN d g s b sg13_lv_nmos W=1u L=0.13u ng=1 m=1
.ends mos_operating_point
