.subckt common_source in out vdd vss
XMN out in vss vss sg13_lv_nmos W=20u L=0.13u ng=1 m=1
RLOAD vdd out 20k
.ends common_source
