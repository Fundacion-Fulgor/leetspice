.lib ${pdk_root}/ihp-sg13g2/libs.tech/ngspice/models/cornerMOSlv.lib mos_${corner}
.include submission.spice
.temp ${temperature}
VDD vdd 0 1.2
VIN in 0 0.50 AC 1
CLOAD out 0 100f
XDUT in out vdd 0 common_source
.control
op
let output_voltage=v(out)
let supply_current=abs(i(VDD))
ac dec 20 1 100g
let gain_vector=mag(v(out))
let ac_gain=gain_vector[0]
let gain_3db=ac_gain/sqrt(2)
meas ac bandwidth WHEN gain_vector=gain_3db FALL=1
echo output_voltage $$&op1.output_voltage > results.data
echo supply_current $$&op1.supply_current >> results.data
echo ac_gain $$&ac_gain >> results.data
echo bandwidth $$&bandwidth >> results.data
quit
.endc
.end
