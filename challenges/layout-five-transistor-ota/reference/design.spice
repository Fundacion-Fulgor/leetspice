.subckt ota5 inp inn out bias vdd vss
M1 mirror inp tail vss sg13_lv_nmos W=4u L=0.5u ng=2 m=1
M2 out inn tail vss sg13_lv_nmos W=4u L=0.5u ng=2 m=1
M3 tail bias vss vss sg13_lv_nmos W=8u L=0.5u ng=4 m=1
M4 mirror mirror vdd vdd sg13_lv_pmos W=8u L=0.5u ng=4 m=1
M5 out mirror vdd vdd sg13_lv_pmos W=8u L=0.5u ng=4 m=1
.ends ota5
