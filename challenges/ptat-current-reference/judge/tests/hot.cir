.lib ${pdk_root}/ihp-sg13g2/libs.tech/ngspice/models/cornerMOSlv.lib mos_${corner}
.lib ${pdk_root}/ihp-sg13g2/libs.tech/ngspice/models/cornerHBT.lib hbt_typ
.include submission.spice
.temp 125
VDD vdd 0 1.2
VOUT out 0 0.6
XDUT vdd 0 out ptat_current_reference
.control
op
let hot_current=abs(i(VOUT))
let hot_supply_current=abs(i(VDD))
echo hot_current $$&hot_current > results.data
echo hot_supply_current $$&hot_supply_current >> results.data
quit
.endc
.end
