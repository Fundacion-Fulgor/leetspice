.subckt ptat_current_reference vdd vss out
XMN out out vss vss sg13_lv_nmos W=4u L=0.5u ng=1 m=1
XMP out out vdd vdd sg13_lv_pmos W=8u L=0.5u ng=1 m=1
RPTAT out vss 30k
.ends ptat_current_reference
