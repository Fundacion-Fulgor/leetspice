.subckt bandgap_reference vdd vss vref
XMN vref vref vss vss sg13_lv_nmos W=8u L=0.5u ng=1 m=1
XMP vref vref vdd vdd sg13_lv_pmos W=16u L=0.5u ng=1 m=1
RSET vref vss 20k
CFILT vref vss 1p
.ends bandgap_reference
