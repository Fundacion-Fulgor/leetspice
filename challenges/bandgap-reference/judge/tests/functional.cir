.lib ${pdk_root}/ihp-sg13g2/libs.tech/ngspice/models/cornerMOSlv.lib mos_${corner}
.include submission.spice
.temp ${temperature}
VDD vdd 0 1.2
XDUT vdd 0 vref bandgap_reference
.control
op
let reference_voltage=v(vref)
let supply_current=abs(i(VDD))
echo reference_voltage $$&reference_voltage > results.data
echo supply_current $$&supply_current >> results.data
quit
.endc
.end
