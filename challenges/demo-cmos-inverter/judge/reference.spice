* Reference submission used to qualify the SG13G2 inverter challenge.
.subckt inverter in out vdd vss
XNMOS out in vss vss sg13_lv_nmos W=1u L=0.13u ng=1 m=1
XPMOS out in vdd vdd sg13_lv_pmos W=2u L=0.13u ng=1 m=1
.ends inverter
