* IHP SG13G2 low-voltage CMOS inverter.
* Models and analyses are included by the server-owned ngspice testbench.
.subckt inverter in out vdd vss
XNMOS out in vss vss sg13_lv_nmos W=4u L=0.13u ng=1 m=1
XPMOS out in vdd vdd sg13_lv_pmos W=0.3u L=0.13u ng=1 m=1
.ends inverter
