.subckt current_mirror iref out vss
X1 iref iref vss vss sg13_lv_nmos W=2u L=0.5u ng=2 m=1
X2 out iref vss vss sg13_lv_nmos W=2u L=0.5u ng=2 m=1
.ends current_mirror
