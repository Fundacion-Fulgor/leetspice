.lib ${pdk_root}/ihp-sg13g2/libs.tech/ngspice/models/cornerMOSlv.lib mos_${corner}
.include submission.spice
.temp ${temperature}
VDD vdd 0 1.2
VUP up 0 0
VDN dn 0 0
VOUT out 0 0.6
XDUT up dn out vdd 0 charge_pump
.control
op
let output_current=abs(i(VOUT))
let supply_current=abs(i(VDD))
echo output_current $$&output_current > results.data
echo supply_current $$&supply_current >> results.data
quit
.endc
.end
