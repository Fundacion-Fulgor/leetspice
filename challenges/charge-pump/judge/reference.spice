.subckt charge_pump up dn out vdd vss
XUP out up vdd vdd sg13_lv_pmos W=8u L=0.5u ng=1 m=1
XDN out dn vss vss sg13_lv_nmos W=4u L=0.5u ng=1 m=1
COUT out vss 200f
.ends charge_pump
