.subckt basic_current_mirror iref out vss
XREF iref iref vss vss sg13_lv_nmos W=2u L=0.5u ng=1 m=1
RLEAK out vss 1meg
.ends basic_current_mirror
