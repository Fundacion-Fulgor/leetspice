.subckt compensated_op_amp_capstone inp inn out vdd vss
XINP n1 inp tail vss sg13_lv_nmos W=10u L=0.5u ng=2 m=1
XINN first inn tail vss sg13_lv_nmos W=10u L=0.5u ng=2 m=1
XLP n1 n1 vdd vdd sg13_lv_pmos W=20u L=0.5u ng=2 m=1
XLN first n1 vdd vdd sg13_lv_pmos W=20u L=0.5u ng=2 m=1
XSECOND out first vss vss sg13_lv_nmos W=30u L=0.5u ng=2 m=1
RLOAD vdd out 20k
RTAIL tail vss 5k
CC first out 2p
.ends compensated_op_amp_capstone
